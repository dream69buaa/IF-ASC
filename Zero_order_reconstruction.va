//////////////////////////////////////////////////////////////////////////
// @Author: Jinbo Chen
// @Design: zero order reconstruction from UP/DN spikes of comparator in IF-ASC
// @E-mail: chenjinbo@westlake.edu.cn
//////////////////////////////////////////////////////////////////////////

`include "constants.vams"
`include "disciplines.vams"

module ZOH_Reconstruction (up, dn, out);
input up, dn;
output out;
electrical up, dn, out;

parameter real vth_spike = 300m;	// to judge the occurrence of up/dn spikes
real temp;	// to store reconstruction value

analog begin

	@(initial_step) begin
		temp = 0;	// initialize temp value
	end

	@(cross(V(up)-vth_spike, +1)) begin	// up crossing
		temp = temp + 1;
	end

	@(cross(V(dn)-vth_spike, +1)) begin	// down crossing
		temp = temp - 1;
	end

	V(out) <+ temp;

end

endmodule
